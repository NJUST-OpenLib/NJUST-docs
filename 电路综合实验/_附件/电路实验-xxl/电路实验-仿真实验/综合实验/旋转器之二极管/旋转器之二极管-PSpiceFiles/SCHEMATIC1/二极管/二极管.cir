** Profile: "SCHEMATIC1-二极管"  [ d:\大学文件\课程学习\大二上\电路实验仿真\082肖心亮924110800231（评优）\综合实验\旋转器之二极管\旋转器之二极管-pspicefiles\schematic1\二极管.sim ]

** Creating circuit file "二极管.cir"
** WARNING: THIS AUTOMATICALLY GENERATED FILE MAY BE OVERWRITTEN BY SUBSEQUENT SIMULATIONS

*Libraries:
* Profile Libraries :
* Local Libraries :
* From [PSPICE NETLIST] section of E:\Cadence OrCAD\WorkSpace\cdssetup\OrCAD_PSpice\25.1.0\PSpice.ini file:
.lib "E:\Cadence OrCAD\Cadence\tools\pspice\Library\devparam.txt"
.lib "E:\Cadence OrCAD\Cadence\tools\pspice\Library\analog.lib"
.lib "nom.lib"

*Analysis directives:
.DC LIN V_V 0.01 1 0.01
.OPTIONS ADVCONV
.OPTIONS FILEMODELSEARCH
.PROBE64 V(alias(*)) I(alias(*)) W(alias(*)) D(alias(*)) NOISE(alias(*))
.INC "..\SCHEMATIC1.net"

.END
