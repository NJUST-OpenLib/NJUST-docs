** Profile: "SCHEMATIC1-并联谐振电路"  [ D:\大学文件\课程学习\大二上\电路实验仿真\082肖心亮924110800231（评优）\仿真实验（二）正弦交流电路中的阻抗和频率特性研究\仿真\仿真实验并联谐振电路\并联谐振电路-PSpiceFiles\SCHEMATIC1\并联谐振电路.sim ]

** Creating circuit file "并联谐振电路.cir"
** WARNING: THIS AUTOMATICALLY GENERATED FILE MAY BE OVERWRITTEN BY SUBSEQUENT SIMULATIONS

*Libraries:
* Profile Libraries :
* Local Libraries :
* From [PSPICE NETLIST] section of E:\Cadence OrCAD\WorkSpace\cdssetup\OrCAD_PSpice\25.1.0\PSpice.ini file:
.lib "nom.lib"

*Analysis directives:
.AC LIN 10000 1 10000
.OPTIONS ADVCONV
.PROBE64 V(alias(*)) I(alias(*)) W(alias(*)) D(alias(*)) NOISE(alias(*))
.INC "..\SCHEMATIC1.net"

.END
